* NGSPICE file created from nand.ext - technology: sky130A

.subckt nand A B Y VDD VSS
X0 net1 A.t0 VSS.t1 VSS.t0 sky130_fd_pr__nfet_01v8 ad=0.105 pd=1.21 as=0.42 ps=2.84 w=1 l=0.15
X1 Y.t2 B.t0 net1 VSS.t2 sky130_fd_pr__nfet_01v8 ad=0.42 pd=2.84 as=0.105 ps=1.21 w=1 l=0.15
X2 VDD.t3 B.t1 Y.t1 VDD.t2 sky130_fd_pr__pfet_01v8 ad=0.42 pd=2.84 as=0.235 ps=1.47 w=1 l=0.15
X3 Y.t0 A.t1 VDD.t1 VDD.t0 sky130_fd_pr__pfet_01v8 ad=0.235 pd=1.47 as=0.42 ps=2.84 w=1 l=0.15
R0 Y.n1 Y.n0 312.247
R1 Y.n1 Y.t2 154.333
R2 Y.n0 Y.t1 46.2955
R3 Y.n0 Y.t0 46.2955
R4 Y Y.n1 12.8005
R5 Y.n1 Y 6.4005
R6 B B.n0 360.841
R7 B.n0 B.t0 269.385
R8 B.n0 B.t1 202.44
R9 A A.n0 404.221
R10 A.n0 A.t1 249.034
R11 A.n0 A.t0 191.194
R12 VDD.n3 VDD.t3 370.372
R13 VDD.n10 VDD.t1 366.106
R14 VDD.n2 VDD.t2 280
R15 VDD.n8 VDD.t0 280
R16 VDD.n3 VDD.n2 185
R17 VDD.n5 VDD.n4 185
R18 VDD.n6 VDD.n5 185
R19 VDD.n1 VDD.n0 185
R20 VDD.n7 VDD.n1 185
R21 VDD.n9 VDD.n8 185
R22 VDD.n7 VDD.n6 161.5
R23 VDD.n5 VDD.n2 110.27
R24 VDD.n5 VDD.n1 110.27
R25 VDD.n8 VDD.n1 110.27
R26 VDD.n6 VDD.t2 66.5005
R27 VDD.t0 VDD.n7 66.5005
R28 VDD.n4 VDD.n3 13.1884
R29 VDD.n4 VDD.n0 13.1884
R30 VDD.n9 VDD.n0 13.1884
R31 VDD VDD.n10 7.17626
R32 VDD.n10 VDD.n9 4.26717
R33 VSS.t2 VSS.n0 1019.93
R34 VSS.n3 VSS.t0 940.557
R35 VSS.n4 VSS.n3 585
R36 VSS.n2 VSS.n1 585
R37 VSS.n2 VSS.t2 400
R38 VSS.t0 VSS.n2 400
R39 VSS.n4 VSS.n0 269.702
R40 VSS.n3 VSS.n1 181.028
R41 VSS.n5 VSS.t1 147.934
R42 VSS.n1 VSS.n0 77.6287
R43 VSS VSS.n5 7.17626
R44 VSS.n5 VSS.n4 5.81868
C0 A VDD 0.07848f
C1 Y VDD 0.13153f
C2 A B 0.05305f
C3 net1 Y 0.00789f
C4 Y B 0.07442f
C5 A Y 0.02888f
C6 net1 VDD 0
C7 B VDD 0.09948f
C8 Y VSS 0.11303f
C9 B VSS 0.30344f
C10 A VSS 0.30554f
C11 VDD VSS 0.63661f
C12 net1 VSS 0.00867f
C13 VDD.t1 VSS 0.0187f
C14 VDD.n0 VSS 0.00523f
C15 VDD.n1 VSS 0.00586f
C16 VDD.t2 VSS 0.05124f
C17 VDD.n2 VSS 0.02619f
C18 VDD.t3 VSS 0.01895f
C19 VDD.n3 VSS 0.02506f
C20 VDD.n4 VSS 0.00523f
C21 VDD.n5 VSS 0.00586f
C22 VDD.n6 VSS 0.02236f
C23 VDD.n7 VSS 0.02236f
C24 VDD.t0 VSS 0.05124f
C25 VDD.n8 VSS 0.02619f
C26 VDD.n9 VSS 0.00346f
C27 VDD.n10 VSS 0.02043f
C28 A.t1 VSS 0.02596f
C29 A.t0 VSS 0.0227f
C30 A.n0 VSS 0.05936f
C31 B.t1 VSS 0.03106f
C32 B.t0 VSS 0.03827f
C33 B.n0 VSS 0.09254f
C34 Y.t1 VSS 0.01647f
C35 Y.t0 VSS 0.01647f
C36 Y.n0 VSS 0.03502f
C37 Y.t2 VSS 0.06065f
C38 Y.n1 VSS 0.11793f
.ends
