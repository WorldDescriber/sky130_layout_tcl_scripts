** sch_path: /home/heweiwei/ask-projects/chip_project/logic_gates/nand_gate/use_sky130/nand_1/design_circuit/circuit_3/tb_nand.sch
**.subckt tb_nand
x1 A B Y VDD GND nand
C1 Y GND 10f m=1
V1 VDD GND 1.8
V2 A GND pulse(0 1.8 0 100p 100p 4n 8n)
V3 B GND pulse(0 1.8 0 100p 100p 8n 16n)
**** begin user architecture code

.lib /usr/local/share/pdk/sky130A/libs.tech/ngspice/sky130.lib.spice tt

.tran 10p 32n
.save V(A) V(B) V(Y)
.control
run
plot V(A)
plot V(B)
plot V(Y)
.endc

**** end user architecture code
**.ends

* expanding   symbol:  nand.sym # of pins=5
** sym_path: /home/heweiwei/ask-projects/chip_project/logic_gates/nand_gate/use_sky130/nand_1/design_circuit/circuit_3/nand.sym
** sch_path: /home/heweiwei/ask-projects/chip_project/logic_gates/nand_gate/use_sky130/nand_1/design_circuit/circuit_3/nand.sch
*.subckt nand A B Y VDD VSS
**.ipin A
**.ipin B
**.ipin VDD
**.ipin VSS
**.opin Y
*XM1 Y A VDD VDD sky130_fd_pr__pfet_01v8 L=0.15 W=1 nf=1 ad='int((nf+1)/2) * W/nf * 0.29' as='int((nf+2)/2) * W/nf * 0.29' pd='2*int((nf+1)/2) * (W/nf + 0.29)'
*+ ps='2*int((nf+2)/2) * (W/nf + 0.29)' nrd='0.29 / W' nrs='0.29 / W' sa=0 sb=0 sd=0 mult=1 m=1
*XM2 Y B VDD VDD sky130_fd_pr__pfet_01v8 L=0.15 W=1 nf=1 ad='int((nf+1)/2) * W/nf * 0.29' as='int((nf+2)/2) * W/nf * 0.29' pd='2*int((nf+1)/2) * (W/nf + 0.29)'
*+ ps='2*int((nf+2)/2) * (W/nf + 0.29)' nrd='0.29 / W' nrs='0.29 / W' sa=0 sb=0 sd=0 mult=1 m=1
*XM3 Y B net1 VSS sky130_fd_pr__nfet_01v8 L=0.15 W=1 nf=1 ad='int((nf+1)/2) * W/nf * 0.29' as='int((nf+2)/2) * W/nf * 0.29' pd='2*int((nf+1)/2) * (W/nf + 0.29)'
*+ ps='2*int((nf+2)/2) * (W/nf + 0.29)' nrd='0.29 / W' nrs='0.29 / W' sa=0 sb=0 sd=0 mult=1 m=1
*XM4 net1 A VSS VSS sky130_fd_pr__nfet_01v8 L=0.15 W=1 nf=1 ad='int((nf+1)/2) * W/nf * 0.29' as='int((nf+2)/2) * W/nf * 0.29' pd='2*int((nf+1)/2) * (W/nf + 0.29)'
*+ ps='2*int((nf+2)/2) * (W/nf + 0.29)' nrd='0.29 / W' nrs='0.29 / W' sa=0 sb=0 sd=0 mult=1 m=1
*.ends
.include nand_pex.spice

.GLOBAL VDD
.GLOBAL GND
.end
